CFOA Inverting Amplifier BROKEN port swap
VCC 10 0 DC 5
VEE 20 0 DC -5
VIN 1 0 DC 0 AC 1
R1 1 Y 1k
R2 O Y 10k
RL O 0 10k
X_U1 X Y Z O CFOA

.SUBCKT CFOA Y X Z O
VX X 0 DC 0
EX X 0 Y 0 1.0
FZ Z 0 VX 1.0
EO O 0 Z 0 1.0
RZ Z 0 1e6
.ENDS CFOA

.AC DEC 10 1Hz 1MHz
.PROBE
.END
